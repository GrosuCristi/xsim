* xsim reference: LC tank whose inductor alone has an initial current, no uic (D16)
L1 n 0 1m IC=1m Rser=0
C1 n 0 1u
.options reltol=1e-6 abstol=1e-12 vntol=1e-9 gmin=1e-12 numdgt=15 plotwinsize=0 measdgt=15
.tran 0 1m 0 1u
.meas TRAN n0 FIND V(n) AT=0
.meas TRAN il0 FIND I(L1) AT=0
.meas TRAN nmax MAX V(n)
.end
