* xsim reference: 1 ps edge into 1 ohm and 1 mF (tau = 1 ms) on a 100 s run, default maximum step (T3)
V1 in 0 PULSE(0 1 1m 1p 1p 1e9)
R1 in out 1
C1 out 0 1m
.options reltol=1e-6 abstol=1e-12 vntol=1e-9 gmin=1e-12 numdgt=15 plotwinsize=0 measdgt=15
.tran 0 100 0
.meas TRAN v2m FIND V(out) AT=2m
.meas TRAN v5m FIND V(out) AT=5m
.end
