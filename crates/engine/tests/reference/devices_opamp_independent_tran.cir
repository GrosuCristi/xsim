* xsim reference: op-amp (D26) slewing, clipping and recovery against an independent
* macro-model, tests/devices_opamp.rs (stages T1 and T2).
* The macro-model OAM is written independently of devices_opamp_macro.cir: an
* E source for AOL*vd, the state on a 1 uF capacitor charged by
* 1u*SLEW*tanh(e/L) (so dx/dt = SLEW tanh(e/L), L = SLEW*AOL/(2 pi GBW)),
* e = AOL vd - x - c(x), and the span-guarded limits, softplus T(x) and clamp
* c(x) of crates/engine/src/devices/opamp.rs (knee k = 10 mV, G = 1e9,
* m = 0.5 V, supply split 1 uA).
* Run: LTspice.exe -b <deck>.cir, then read the .meas values from <deck>.log.
.param k=0.01 m=0.5 G=1e9 eps=1e-6
.func sp(v) {max(v,0)+k*ln(1+exp(-abs(v)/k))}
.subckt OAM inp inn out vp vn params: aol=1e5 gbw=1e6 slew=0.5e6 rin=2e6 rout=75 hp=1.5 hn=1.5
RIN inp inn {rin}
EA a 0 inp inn {aol}
BHI hi 0 V=(V(vp)-hp+V(vn)+hn)/2+sp((V(vp)-hp-V(vn)-hn)/2)
BLO lo 0 V=(V(vp)-hp+V(vn)+hn)/2-sp((V(vp)-hp-V(vn)-hn)/2)
BC c 0 V=G*(sp(V(x)-V(hi)-m)-sp(V(lo)-m-V(x)))
CX x 0 1u
BX 0 x I=1u*slew*tanh((V(a)-V(x)-V(c))/(slew*aol/(2*pi*gbw)))
BT t 0 V=V(x)-sp(V(x)-V(hi))+sp(V(lo)-V(x))
RO t o {rout}
VS o out 0
BP vp 0 I=I(VS)*(1+tanh(I(VS)/eps))/2
BN vn 0 I=I(VS)*(1-tanh(I(VS)/eps))/2
.ends
* T1: OA_FAST inverting gain -2 on +-15 V into 2 k; a -7.5 V pulse slews, clips, recovers.
VP1 vp1 0 15
VN1 vn1 0 -15
VIN1 in1 0 PULSE(0 -7.5 1u 1n 1n 4u 100u)
R11 in1 n1 1k
R21 n1 out1 2k
RL1 out1 0 2k
XU1 0 n1 out1 vp1 vn1 OAM params: aol=1e5 gbw=10e6 slew=10e6 rin=1e6 rout=50 hp=1.5 hn=1.5
* T2: OA_GP follower on +-5 V, -2 V to 2 V and back.
VP2 vp2 0 5
VN2 vn2 0 -5
VIN2 in2 0 PULSE(-2 2 1u 1n 1n 12u 100u)
XU2 in2 out2 out2 vp2 vn2 OAM
.options plotwinsize=0 numdgt=15 measdgt=15 reltol=1e-9 abstol=1e-15 vntol=1e-12 gmin=1e-15
.save V(out1) V(out2) I(VP1)
.tran 0 30u 0 2n
.meas TRAN a16 FIND V(out1) AT=1.6u
.meas TRAN a40 FIND V(out1) AT=4u
.meas TRAN aip FIND I(VP1) AT=4u
.meas TRAN aup WHEN V(out1)=6 RISE=1
.meas TRAN adn WHEN V(out1)=6 FALL=1
.meas TRAN b4 FIND V(out2) AT=4u
.meas TRAN b8 FIND V(out2) AT=8u
.meas TRAN b12 FIND V(out2) AT=12u
.meas TRAN b28 FIND V(out2) AT=28u
.meas TRAN bup WHEN V(out2)=0 RISE=1
.meas TRAN bdn WHEN V(out2)=0 FALL=1
.end
