* xsim reference: AC-coupled clamps whose DC matrix is singular or nearly so
* in double precision (SR-1), tests/ill_conditioned.rs. Every source is 0 at
* the operating point, so LTspice finds it "by inspection" without factoring
* the matrix; the transient matrix is regular through the capacitors.
* Nodes b: one diode behind 1 mohm; c: one diode behind 1 uohm; e: two
* antiparallel diodes behind 1 uohm (xsim checks the transient of node b
* only, see the test). The 0.1 us maximum step is where
* LTspice's own result has converged.
* LTspice 24 computes kT/q from CODATA-1998 constants, 1.0489e-6 above the
* exact SI value xsim uses. Running LTspice at TEMP = TNOM = 26.9996851609185 degC
* gives its kT/q the value xsim has at 27 degC, so the comparison checks the
* device equations rather than the physical constants.
* Run: LTspice.exe -b <deck>.cir, then read the .meas values from <deck>.log.
V1 s 0 SINE(0 1 1k)
C1 s a 1u
R1 a b 1m
D1 b 0 DD
C2 s d 1u
R2 d c 1u
D2 c 0 DD
C3 s f 1u
R3 f e 1u
D3 e 0 DD
D4 0 e DD
.model DD D(IS=1e-14 N=1 RS=0 CJO=0 TT=0)
.options plotwinsize=0 numdgt=15 measdgt=15 reltol=1e-6 abstol=1e-12 vntol=1e-9 gmin=1e-12 tnom=26.9996851609185
.temp 26.9996851609185
.tran 0 2m 0 0.1u
.meas TRAN vb05 FIND V(b) AT=0.5m
.meas TRAN vb2 FIND V(b) AT=2m
.meas TRAN vc05 FIND V(c) AT=0.5m
.meas TRAN vc2 FIND V(c) AT=2m
.meas TRAN ve05 FIND V(e) AT=0.5m
.meas TRAN ve2 FIND V(e) AT=2m
.end
