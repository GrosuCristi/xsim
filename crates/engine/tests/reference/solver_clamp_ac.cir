* xsim reference: small-signal response of the AC-coupled clamp of
* solver_clamp.cir with R1 = 10 mohm (node b) and 1 mohm (node c), driven by
* the same ideal source (SR-1), tests/ill_conditioned.rs.
* LTspice 24 computes kT/q from CODATA-1998 constants, 1.0489e-6 above the
* exact SI value xsim uses. Running LTspice at TEMP = TNOM = 26.9996851609185 degC
* gives its kT/q the value xsim has at 27 degC, so the comparison checks the
* device equations rather than the physical constants.
* Run: LTspice.exe -b <deck>.cir, then read the .meas values from <deck>.log.
V1 s 0 SINE(0 1 1k) AC 1
C1 s a 1u
R1 a b 10m
D1 b 0 DD
D2 0 b DD
C2 s e 1u
R2 e c 1m
D3 c 0 DD
D4 0 c DD
.model DD D(IS=1e-14 N=1 RS=0 CJO=0 TT=0)
.options plotwinsize=0 numdgt=15 measdgt=15 reltol=1e-6 abstol=1e-12 vntol=1e-9 gmin=1e-12 tnom=26.9996851609185
.temp 26.9996851609185
.ac list 1 1k 1Meg
.meas AC vb1 FIND V(b) AT=1
.meas AC vb1k FIND V(b) AT=1k
.meas AC vb1M FIND V(b) AT=1Meg
.meas AC vc1 FIND V(c) AT=1
.meas AC vc1k FIND V(c) AT=1k
.meas AC vc1M FIND V(c) AT=1Meg
.end
