* xsim reference: capacitive divider, node m reached only through
* capacitors (D15), tests/floating_nodes.rs. LTspice warns "Node m is
* floating." and solves.
* Run: LTspice.exe -b <deck>.cir, then read the .meas values from <deck>.log.
V1 a 0 1 AC 1
C1 a m 1n
C2 m 0 1n
R1 a 0 1k
.options plotwinsize=0 numdgt=15 measdgt=15 reltol=1e-6 abstol=1e-12 vntol=1e-9 gmin=1e-12
.op
.meas OP vm FIND V(m)
.end
