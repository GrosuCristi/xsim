* xsim reference: small-signal response of the capacitive divider of
* floating_capdiv_op.cir (D15), tests/floating_nodes.rs.
* Run: LTspice.exe -b <deck>.cir, then read the .meas values from <deck>.log.
V1 a 0 1 AC 1
C1 a m 1n
C2 m 0 1n
R1 a 0 1k
.options plotwinsize=0 numdgt=15 measdgt=15 reltol=1e-6 abstol=1e-12 vntol=1e-9 gmin=1e-12
.ac list 1 1k 1Meg
.meas AC vm1 FIND V(m) AT=1
.meas AC vm1k FIND V(m) AT=1k
.meas AC vm1M FIND V(m) AT=1Meg
.end
